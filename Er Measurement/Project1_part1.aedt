# Ansys Electronics Desktop project, version 2018.2
project variables:
  $Xsize = 34.85mm
  $Ysize = 15.8mm
  $Zsize = 100mm
  $HoleRadius = 2mm
materials:
  vacuum: permittivity=1
  copper: permeability=0.999991 conductivity=58000000

design HFSSDesign1 (HFSS, DrivenModal, model units mm)
geometry:
  Box1 [vacuum] = box(corner=(0mm, 0mm, 0mm), size=($Xsize, $Ysize, $Zsize))
  Box2 [vacuum] = box(corner=(0mm, 0mm, $Zsize/2 -$CavityLength/2), size=($Xsize, $Ysize, $CavityLength))
  Cylinder1 = cylinder(axis=Z, base_centre=($Xsize/2, $Ysize/2, $Zsize/2-$CavityLength/2), radius=$HoleRadius, height=$CavityLength)
  Box2.subtract(Cylinder1)
boundaries and excitations:
  FiniteCond1: Finite Conductivity Faces=Box1.face(+y, +x, -y, -x) UseMaterial Material=copper IsInternal
  FiniteCond2: Finite Conductivity Faces=Box2.face(+z) UseMaterial Material=copper IsInternal
  FiniteCond3: Finite Conductivity Faces=Box2.face(-z) UseMaterial Material=copper IsInternal
  1: Wave Port Faces=Box1.face(-z) NumModes=1 Modes{Mode1{IntLine{middle of Box1.edge(6 of 12) -> middle of Box1.edge(8 of 12)} CharImp=Zpi}}
  2: Wave Port Faces=Box1.face(+z) NumModes=1 Modes{Mode1{IntLine{middle of Box1.edge(4 of 12) -> middle of Box1.edge(2 of 12)} CharImp=Zpi}}
setups:
  Setup1: HfssDriven Frequency=6GHz MaxDeltaS=0.02 MaximumPasses=6 MinimumPasses=1 MinimumConvergedPasses=1 PercentRefinement=30 BasisOrder=1 PortAccuracy=2
    sweep Sweep: 5.7GHz to 6.3GHz, 24 points; Type=Discrete
source amplitudes:
  1:1: 1W 0deg
  2:1: 0W 0deg
optimetrics:
  ParametricSetup1: Parametric Sim._Setups=[Setup1]
    sweep $HoleRadius: LIN 0.5mm 6mm 0.5mm
output variables:
  P = sqrt(mag(S(1,1))^2+mag(S(2,1))^2)
field plots:
  Mag_E1: E Field in Box2 on Setup1 : LastAdaptive at Freq=6GHz Phase=0deg
reports:
  S Parameter Plot 1: dB(S(2,1)) vs Freq on Setup1 : Sweep [$HoleRadius=all]; markers m1 at 5.9869565GHz, m2 at 5.9608696GHz
