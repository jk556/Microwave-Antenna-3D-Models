# Ansys Electronics Desktop project, version 2024.1
materials:
  vacuum: permittivity=1
  pec: conductivity=1e+30
  Teflon (tm): permittivity=2.1 dielectric_loss_tangent=0.001

design HFSSDesign1 (HFSS, HFSS Modal Network, model units mm)
options: Save_Adaptive_support_files
variables:
  a = 22.86mm
  L = 50mm
  b = 10.16mm
  th = 0.5mm
  lambda = (300/10.368) mm
  Ra = (1.27/2) mm
  h = 7mm
  Rb = (4.25/2) mm
geometry:
  Box1 = box(corner=(-a/2, 0mm, 0mm), size=(a, L, b))
  Box2 [pec] = box(corner=(-a/2-th, -th, -th), size=(a+2*th, L+th, b+2*th))
  Box2.subtract(Box1)
  core [pec] = cylinder(axis=Z, base_centre=(0mm, lambda/4, -5mm), radius=Ra, height=5 mm+h)
  Cylinder2 [Teflon (tm)] = cylinder(axis=Z, base_centre=(0mm, lambda/4, -5mm), radius=Rb, height=5mm)
  Cylinder1_1 = core.copy()
  Cylinder2.subtract(Cylinder1_1)
  SHIELD [pec] = sweep_along_normal(Cylinder2.face(side), length=0.1mm)
  Cylinder2_1 = Cylinder2.copy()
  Box2.subtract(Cylinder2_1)
  Cylinder1_2 = core.copy()
  Box2.subtract(Cylinder1_2)
  Cylinder2_SweepFaceAlongNormal1_1 = SHIELD.copy()
  Box2.subtract(Cylinder2_SweepFaceAlongNormal1_1)
  Region [vacuum] = region(percentage_offset: +X=20, -X=20, +Y=70, -Y=15, +Z=20, -Z=20)
  back_cap [pec] = cylinder(axis=Z, base_centre=(0mm, 7.2337963mm, -5mm), radius=2.3499475mm, height=-1mm)
boundaries and excitations:
  Rad1: Radiation Faces=Region.face(all 6)
  1: Wave Port Faces=Cylinder2.face(-z end) WavePortType=Modal NumModes=1 Modes{Mode1{CharImp=Zpi}}
setups:
  Setup1: HfssDriven Frequency=11GHz MaxDeltaS=0.02 MaximumPasses=12 MinimumPasses=1 MinimumConvergedPasses=1 PercentRefinement=30 BasisOrder=1 PortAccuracy=2 DrivenSolverType="Direct Solver"
    sweep Sweep: 9.8GHz to 11GHz, 200 points; Type=Fast SaveFields
source amplitudes:
  1:1: 1W 0deg
radiation setups:
  Infinite Sphere1: Infinite Sphere Theta=-180deg..180deg step 1deg Phi=0deg..360deg step 1deg
reports:
  XY Plot 1: dB(S(1,1)) vs Freq on Setup1 : Sweep
  XY Plot 2: VSWR(1) vs Freq on Setup1 : Sweep
  3D Polar Plot 1: dB(RealizedGainTotal) vs Phi, Theta on Setup1 : LastAdaptive, Infinite Sphere1 [Freq=11GHz]
  Radiation Pattern 1: dB(RealizedGainTotal) vs Theta on Setup1 : LastAdaptive, Infinite Sphere1 [Phi=90deg Freq=11GHz]
  Radiation Pattern 2: dB(RealizedGainTotal) vs Theta on Setup1 : Sweep, Infinite Sphere1 [Phi=90deg Freq=10.3427GHz]
  Radiation Pattern 3: dB(RealizedGainTotal) vs Phi on Setup1 : Sweep, Infinite Sphere1 [Theta=90deg Freq=10.3427GHz]
