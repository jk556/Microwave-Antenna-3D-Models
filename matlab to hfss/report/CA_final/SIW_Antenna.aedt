# Ansys Electronics Desktop project, version 2020.2
materials:
  vacuum: permittivity=1
  Rogers RO4003 (tm): permittivity=3.55 dielectric_loss_tangent=0.0027
  copper: permeability=0.999991 conductivity=58000000

design SIW Waveguide Antenna (HFSS, DrivenModal, model units mm)
geometry:
  Air_out [Rogers RO4003 (tm)] = box(corner=(-18m, -45m, -31m), size=(36m, 90m, 61m))
  Air_in1 = box(corner=(-18m, -2m, -31m), size=(36m, 4m, 61m))
  semi_up1 = box(corner=(-18m, 2m, -31m), size=(36m, 1m, 61m))
  semi_down1 = box(corner=(-18m, -3m, -31m), size=(36m, 1m, 61m))
  Air_out.subtract(semi_up1)
  Air_out.subtract(semi_down1)
  Air_out.subtract(Air_in1)
  semi_up [copper, solve inside] = box(corner=(-18m, 2m, -31m), size=(36m, 1m, 61m))
  semi_down [copper, solve inside] = box(corner=(-18m, -3m, -31m), size=(36m, 1m, 61m))
  Air_hole1 = box(corner=(-4.25m, 2m, -16m), size=(1m, 1m, 31m))
  semi_up.subtract(Air_hole1)
  Air_hole [Rogers RO4003 (tm)] = box(corner=(-4.25m, 2m, -16m), size=(1m, 1m, 31m))
  cylinder1_1 [copper, solve inside] = cylinder(axis=Y, base_centre=(-8.5m, -2m, -29m), radius=1m, height=4m)
  cylinder_1_1 [copper, solve inside] = cylinder(axis=Y, base_centre=(8.5m, -2m, -29m), radius=1m, height=4m)
  cylinder2_1 [copper, solve inside] = cylinder(axis=Y, base_centre=(-8.5m, -2m, -26m), radius=1m, height=4m)
  cylinder_2_1 [copper, solve inside] = cylinder(axis=Y, base_centre=(8.5m, -2m, -26m), radius=1m, height=4m)
  cylinder3_1 [copper, solve inside] = cylinder(axis=Y, base_centre=(-8.5m, -2m, -23m), radius=1m, height=4m)
  cylinder_3_1 [copper, solve inside] = cylinder(axis=Y, base_centre=(8.5m, -2m, -23m), radius=1m, height=4m)
  cylinder4_1 [copper, solve inside] = cylinder(axis=Y, base_centre=(-8.5m, -2m, -20m), radius=1m, height=4m)
  cylinder_4_1 [copper, solve inside] = cylinder(axis=Y, base_centre=(8.5m, -2m, -20m), radius=1m, height=4m)
  cylinder5_1 [copper, solve inside] = cylinder(axis=Y, base_centre=(-8.5m, -2m, -17m), radius=1m, height=4m)
  cylinder_5_1 [copper, solve inside] = cylinder(axis=Y, base_centre=(8.5m, -2m, -17m), radius=1m, height=4m)
  cylinder6_1 [copper, solve inside] = cylinder(axis=Y, base_centre=(-8.5m, -2m, -14m), radius=1m, height=4m)
  cylinder_6_1 [copper, solve inside] = cylinder(axis=Y, base_centre=(8.5m, -2m, -14m), radius=1m, height=4m)
  cylinder7_1 [copper, solve inside] = cylinder(axis=Y, base_centre=(-8.5m, -2m, -11m), radius=1m, height=4m)
  cylinder_7_1 [copper, solve inside] = cylinder(axis=Y, base_centre=(8.5m, -2m, -11m), radius=1m, height=4m)
  cylinder8_1 [copper, solve inside] = cylinder(axis=Y, base_centre=(-8.5m, -2m, -8m), radius=1m, height=4m)
  cylinder_8_1 [copper, solve inside] = cylinder(axis=Y, base_centre=(8.5m, -2m, -8m), radius=1m, height=4m)
  cylinder9_1 [copper, solve inside] = cylinder(axis=Y, base_centre=(-8.5m, -2m, -5m), radius=1m, height=4m)
  cylinder_9_1 [copper, solve inside] = cylinder(axis=Y, base_centre=(8.5m, -2m, -5m), radius=1m, height=4m)
  cylinder10_1 [copper, solve inside] = cylinder(axis=Y, base_centre=(-8.5m, -2m, -2m), radius=1m, height=4m)
  cylinder_10_1 [copper, solve inside] = cylinder(axis=Y, base_centre=(8.5m, -2m, -2m), radius=1m, height=4m)
  cylinder11_1 [copper, solve inside] = cylinder(axis=Y, base_centre=(-8.5m, -2m, 1m), radius=1m, height=4m)
  cylinder_11_1 [copper, solve inside] = cylinder(axis=Y, base_centre=(8.5m, -2m, 1m), radius=1m, height=4m)
  cylinder12_1 [copper, solve inside] = cylinder(axis=Y, base_centre=(-8.5m, -2m, 4m), radius=1m, height=4m)
  cylinder_12_1 [copper, solve inside] = cylinder(axis=Y, base_centre=(8.5m, -2m, 4m), radius=1m, height=4m)
  cylinder13_1 [copper, solve inside] = cylinder(axis=Y, base_centre=(-8.5m, -2m, 7m), radius=1m, height=4m)
  cylinder_13_1 [copper, solve inside] = cylinder(axis=Y, base_centre=(8.5m, -2m, 7m), radius=1m, height=4m)
  cylinder14_1 [copper, solve inside] = cylinder(axis=Y, base_centre=(-8.5m, -2m, 10m), radius=1m, height=4m)
  cylinder_14_1 [copper, solve inside] = cylinder(axis=Y, base_centre=(8.5m, -2m, 10m), radius=1m, height=4m)
  cylinder15_1 [copper, solve inside] = cylinder(axis=Y, base_centre=(-8.5m, -2m, 13m), radius=1m, height=4m)
  cylinder_15_1 [copper, solve inside] = cylinder(axis=Y, base_centre=(8.5m, -2m, 13m), radius=1m, height=4m)
  cylinder16_1 [copper, solve inside] = cylinder(axis=Y, base_centre=(-8.5m, -2m, 16m), radius=1m, height=4m)
  cylinder_16_1 [copper, solve inside] = cylinder(axis=Y, base_centre=(8.5m, -2m, 16m), radius=1m, height=4m)
  cylinder17_1 [copper, solve inside] = cylinder(axis=Y, base_centre=(-8.5m, -2m, 19m), radius=1m, height=4m)
  cylinder_17_1 [copper, solve inside] = cylinder(axis=Y, base_centre=(8.5m, -2m, 19m), radius=1m, height=4m)
  cylinder18_1 [copper, solve inside] = cylinder(axis=Y, base_centre=(-8.5m, -2m, 22m), radius=1m, height=4m)
  cylinder_18_1 [copper, solve inside] = cylinder(axis=Y, base_centre=(8.5m, -2m, 22m), radius=1m, height=4m)
  cylinder19_1 [copper, solve inside] = cylinder(axis=Y, base_centre=(-8.5m, -2m, 25m), radius=1m, height=4m)
  cylinder_19_1 [copper, solve inside] = cylinder(axis=Y, base_centre=(8.5m, -2m, 25m), radius=1m, height=4m)
  cylinder20_1 [copper, solve inside] = cylinder(axis=Y, base_centre=(-8.5m, -2m, 28m), radius=1m, height=4m)
  cylinder_20_1 [copper, solve inside] = cylinder(axis=Y, base_centre=(8.5m, -2m, 28m), radius=1m, height=4m)
  Rectangle1 = rectangle(corner=(-18mm, 2mm, -31mm), x_size=36mm, y_size=-4mm)
  Rectangle2 = rectangle(corner=(18mm, 2mm, 30mm), x_size=-36mm, y_size=-4mm)
  Air_in [Rogers RO4003 (tm)] = imported_body()
boundaries and excitations:
  1: Wave Port Objects=Rectangle1 NumModes=1 Modes{Mode1{CharImp=Zpi}}
  2: Wave Port Objects=Rectangle2 NumModes=1 Modes{Mode1{CharImp=Zpi}}
setups:
  Setup2: HfssDriven Frequency=10GHz MaxDeltaS=0.02 MaximumPasses=6 MinimumPasses=1 MinimumConvergedPasses=1 PercentRefinement=30 BasisOrder=1 PortAccuracy=2
    sweep Sweep: 9.5GHz to 10.5GHz, 5 points; Type=Interpolating InterpTolerance=0.5 InterpMaxSolns=250 InterpUsePortImped=false PassivityErrorTolerance=0.0001
source amplitudes:
  1:1: 1W 0deg
  2:1: 0W 0deg
field plots:
  Mag_E1: E Field in Air_in on Setup2 : LastAdaptive at Freq=10GHz Phase=0deg
  Mag_E2: E Field in Air_out on Setup2 : LastAdaptive at Freq=10GHz Phase=0deg
